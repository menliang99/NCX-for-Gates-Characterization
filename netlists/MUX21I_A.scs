simulator lang=spice
// Design: 130nm_BOOLEAN_AND_SPECIAL_final/LATSR_E
.SUBCKT MUX21I_A D0 D1 SD GND VDD Z
simulator lang=spectre

// Library name: 130nm_BOOLEAN_AND_SPECIAL_final

// View name: schematic
TPS1 (Z SD net68 VDD) pfet l=120.0n w=1.16u nf=1 m=1 ngcon=1 rf_rsub=1 plnest=-1 pld200=-1 pwd100=-1 lstis=1 lnws=0 rgatemod=0 rbodymod=0 panw1=0p panw2=0p panw3=0p panw4=0p panw5=0p panw6=0p panw7=0p panw8=0p panw9=0p panw10=0p dtemp=0
TPS0 (Z S0 net59 VDD) pfet l=120.0n w=1.16u nf=1 m=1 ngcon=1 rf_rsub=1 plnest=-1 pld200=-1 pwd100=-1 lstis=1 lnws=0 rgatemod=0 rbodymod=0 panw1=0p panw2=0p panw3=0p panw4=0p panw5=0p panw6=0p panw7=0p panw8=0p panw9=0p panw10=0p dtemp=0
TPD0 (net68 D0 VDD VDD) pfet l=120.0n w=1.16u nf=1 m=1 ngcon=1 rf_rsub=1 plnest=-1 pld200=-1 pwd100=-1 lstis=1 lnws=0 rgatemod=0 rbodymod=0 panw1=0p panw2=0p panw3=0p panw4=0p panw5=0p panw6=0p panw7=0p panw8=0p panw9=0p panw10=0p dtemp=0
TPD1 (net59 D1 VDD VDD) pfet l=120.0n w=1.16u nf=1 m=1 ngcon=1 rf_rsub=1 plnest=-1 pld200=-1 pwd100=-1 lstis=1 lnws=0 rgatemod=0 rbodymod=0 panw1=0p panw2=0p panw3=0p panw4=0p panw5=0p panw6=0p panw7=0p panw8=0p panw9=0p panw10=0p dtemp=0
TPSD (S0 SD VDD VDD) pfet l=120.0n w=570.0n nf=1 m=1 ngcon=1 rf_rsub=1 plnest=-1 pld200=-1 pwd100=-1 lstis=1 lnws=0 rgatemod=0 rbodymod=0 panw1=0p panw2=0p panw3=0p panw4=0p panw5=0p panw6=0p panw7=0p panw8=0p panw9=0p panw10=0p dtemp=0
TND0 (net43 D0 GND GND) nfet l=120.0n w=400n nf=1 m=1 ngcon=1 rf_rsub=1 plnest=-1 pld200=-1 pwd100=-1 lstis=1 lnws=0 rgatemod=0 rbodymod=0 panw1=0p panw2=0p panw3=0p panw4=0p panw5=0p panw6=0p panw7=0p panw8=0p panw9=0p panw10=0p dtemp=0
TND1 (net40 D1 GND GND) nfet l=120.0n w=400n nf=1 m=1 ngcon=1 rf_rsub=1 plnest=-1 pld200=-1 pwd100=-1 lstis=1 lnws=0 rgatemod=0 rbodymod=0 panw1=0p panw2=0p panw3=0p panw4=0p panw5=0p panw6=0p panw7=0p panw8=0p panw9=0p panw10=0p dtemp=0
TNS0 (Z S0 net43 GND) nfet l=120.0n w=400n nf=1 m=1 ngcon=1 rf_rsub=1 plnest=-1 pld200=-1 pwd100=-1 lstis=1 lnws=0 rgatemod=0 rbodymod=0 panw1=0p panw2=0p panw3=0p panw4=0p panw5=0p panw6=0p panw7=0p panw8=0p panw9=0p panw10=0p dtemp=0
TNS1 (Z SD net40 GND) nfet l=120.0n w=400n nf=1 m=1 ngcon=1 rf_rsub=1 plnest=-1 pld200=-1 pwd100=-1 lstis=1 lnws=0 rgatemod=0 rbodymod=0 panw1=0p panw2=0p panw3=0p panw4=0p panw5=0p panw6=0p panw7=0p panw8=0p panw9=0p panw10=0p dtemp=0
TNSD (S0 SD GND GND) nfet l=120.0n w=440.0n nf=1 m=1 ngcon=1 rf_rsub=1 plnest=-1 pld200=-1 pwd100=-1 lstis=1 lnws=0 rgatemod=0 rbodymod=0 panw1=0p panw2=0p panw3=0p panw4=0p panw5=0p panw6=0p panw7=0p panw8=0p panw9=0p panw10=0p dtemp=0
simulator lang=spice
.ENDS
