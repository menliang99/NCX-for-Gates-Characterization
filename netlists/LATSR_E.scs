simulator lang=spice
// Design: 130nm_BOOLEAN_AND_SPECIAL_final/LATSR_E
.SUBCKT LATSR_E CLK D RN S Q QBAR GND VDD
simulator lang=spectre

// 130nm_BOOLEAN_AND_SPECIAL_final/LATSR_E/schematic
TNQM1 (Q L1_TP GND GND) nfet l=120.0n w=1.57u nf=1 m=1 ngcon=1 rf_rsub=1 plnest=-1 pld200=-1 pwd100=-1 lstis=1 lnws=0 rgatemod=0 rbodymod=0 panw1=0p panw2=0p panw3=0p panw4=0p panw5=0p panw6=0p panw7=0p panw8=0p panw9=0p panw10=0p dtemp=0
TNQBARM1 (QBAR net0133 GND GND) nfet l=120.0n w=1.15u nf=1 m=1 ngcon=1 rf_rsub=1 plnest=-1 pld200=-1 pwd100=-1 lstis=1 lnws=0 rgatemod=0 rbodymod=0 panw1=0p panw2=0p panw3=0p panw4=0p panw5=0p panw6=0p panw7=0p panw8=0p panw9=0p panw10=0p dtemp=0
TNCLK2 (L1_TP CLK net102 GND) nfet l=120.0n w=1.13u nf=1 m=1 ngcon=1 rf_rsub=1 plnest=-1 pld200=-1 pwd100=-1 lstis=1 lnws=0 rgatemod=0 rbodymod=0 panw1=0p panw2=0p panw3=0p panw4=0p panw5=0p panw6=0p panw7=0p panw8=0p panw9=0p panw10=0p dtemp=0
TNS (L1_TP S GND GND) nfet l=120.0n w=640.0n nf=1 m=1 ngcon=1 rf_rsub=1 plnest=-1 pld200=-1 pwd100=-1 lstis=1 lnws=0 rgatemod=0 rbodymod=0 panw1=0p panw2=0p panw3=0p panw4=0p panw5=0p panw6=0p panw7=0p panw8=0p panw9=0p panw10=0p dtemp=0
TND (net84 D GND GND) nfet l=120.0n w=970.0n nf=1 m=1 ngcon=1 rf_rsub=1 plnest=-1 pld200=-1 pwd100=-1 lstis=1 lnws=0 rgatemod=0 rbodymod=0 panw1=0p panw2=0p panw3=0p panw4=0p panw5=0p panw6=0p panw7=0p panw8=0p panw9=0p panw10=0p dtemp=0
TNCLK (net190 CLK GND GND) nfet l=120.0n w=400.0n nf=1 m=1 ngcon=1 rf_rsub=1 plnest=-1 pld200=-1 pwd100=-1 lstis=1 lnws=0 rgatemod=0 rbodymod=0 panw1=0p panw2=0p panw3=0p panw4=0p panw5=0p panw6=0p panw7=0p panw8=0p panw9=0p panw10=0p dtemp=0
TNRN (net84 RN net102 GND) nfet l=120.0n w=970.0n nf=1 m=1 ngcon=1 rf_rsub=1 plnest=-1 pld200=-1 pwd100=-1 lstis=1 lnws=0 rgatemod=0 rbodymod=0 panw1=0p panw2=0p panw3=0p panw4=0p panw5=0p panw6=0p panw7=0p panw8=0p panw9=0p panw10=0p dtemp=0
TNCLKN (L1_TP net190 net0119 GND) nfet l=120.0n w=640.0n nf=1 m=1 ngcon=1 rf_rsub=1 plnest=-1 pld200=-1 pwd100=-1 lstis=1 lnws=0 rgatemod=0 rbodymod=0 panw1=0p panw2=0p panw3=0p panw4=0p panw5=0p panw6=0p panw7=0p panw8=0p panw9=0p panw10=0p dtemp=0
TNPRE (net0133 L1_TP GND GND) nfet l=120.0n w=1.47u nf=1 m=1 ngcon=1 rf_rsub=1 plnest=-1 pld200=-1 pwd100=-1 lstis=1 lnws=0 rgatemod=0 rbodymod=0 panw1=0p panw2=0p panw3=0p panw4=0p panw5=0p panw6=0p panw7=0p panw8=0p panw9=0p panw10=0p dtemp=0
TNRN2 (net0124 RN GND GND) nfet l=120.0n w=640.0n nf=1 m=1 ngcon=1 rf_rsub=1 plnest=-1 pld200=-1 pwd100=-1 lstis=1 lnws=0 rgatemod=0 rbodymod=0 panw1=0p panw2=0p panw3=0p panw4=0p panw5=0p panw6=0p panw7=0p panw8=0p panw9=0p panw10=0p dtemp=0
TNHLD (net0124 net0133 net0119 GND) nfet l=120.0n w=640.0n nf=1 m=1 ngcon=1 rf_rsub=1 plnest=-1 pld200=-1 pwd100=-1 lstis=1 lnws=0 rgatemod=0 rbodymod=0 panw1=0p panw2=0p panw3=0p panw4=0p panw5=0p panw6=0p panw7=0p panw8=0p panw9=0p panw10=0p dtemp=0
TPQM1 (Q L1_TP VDD VDD) pfet l=120.0n w=1.97u nf=1 m=1 ngcon=1 rf_rsub=1 plnest=-1 pld200=-1 pwd100=-1 lstis=1 lnws=0 rgatemod=0 rbodymod=0 panw1=0p panw2=0p panw3=0p panw4=0p panw5=0p panw6=0p panw7=0p panw8=0p panw9=0p panw10=0p dtemp=0
TPQBARM1 (QBAR net0133 VDD VDD) pfet l=120.0n w=1.8u nf=1 m=1 ngcon=1 rf_rsub=1 plnest=-1 pld200=-1 pwd100=-1 lstis=1 lnws=0 rgatemod=0 rbodymod=0 panw1=0p panw2=0p panw3=0p panw4=0p panw5=0p panw6=0p panw7=0p panw8=0p panw9=0p panw10=0p dtemp=0
TPCLKN (L1_TP net190 net102 VDD) pfet l=120.0n w=1.54u nf=1 m=1 ngcon=1 rf_rsub=1 plnest=-1 pld200=-1 pwd100=-1 lstis=1 lnws=0 rgatemod=0 rbodymod=0 panw1=0p panw2=0p panw3=0p panw4=0p panw5=0p panw6=0p panw7=0p panw8=0p panw9=0p panw10=0p dtemp=0
TPS2 (net075 S VDD VDD) pfet l=120.0n w=1.43u nf=1 m=1 ngcon=1 rf_rsub=1 plnest=-1 pld200=-1 pwd100=-1 lstis=1 lnws=0 rgatemod=0 rbodymod=0 panw1=0p panw2=0p panw3=0p panw4=0p panw5=0p panw6=0p panw7=0p panw8=0p panw9=0p panw10=0p dtemp=0
TPCLK2 (L1_TP CLK net095 VDD) pfet l=120.0n w=1.43u nf=1 m=1 ngcon=1 rf_rsub=1 plnest=-1 pld200=-1 pwd100=-1 lstis=1 lnws=0 rgatemod=0 rbodymod=0 panw1=0p panw2=0p panw3=0p panw4=0p panw5=0p panw6=0p panw7=0p panw8=0p panw9=0p panw10=0p dtemp=0
TPPRE (net0133 L1_TP VDD VDD) pfet l=120.0n w=1.49u nf=1 m=1 ngcon=1 rf_rsub=1 plnest=-1 pld200=-1 pwd100=-1 lstis=1 lnws=0 rgatemod=0 rbodymod=0 panw1=0p panw2=0p panw3=0p panw4=0p panw5=0p panw6=0p panw7=0p panw8=0p panw9=0p panw10=0p dtemp=0
TPCLK (net190 CLK VDD VDD) pfet l=120.0n w=790.0n nf=1 m=1 ngcon=1 rf_rsub=1 plnest=-1 pld200=-1 pwd100=-1 lstis=1 lnws=0 rgatemod=0 rbodymod=0 panw1=0p panw2=0p panw3=0p panw4=0p panw5=0p panw6=0p panw7=0p panw8=0p panw9=0p panw10=0p dtemp=0
TPD (net103 D VDD VDD) pfet l=120.0n w=1.9u nf=1 m=1 ngcon=1 rf_rsub=1 plnest=-1 pld200=-1 pwd100=-1 lstis=1 lnws=0 rgatemod=0 rbodymod=0 panw1=0p panw2=0p panw3=0p panw4=0p panw5=0p panw6=0p panw7=0p panw8=0p panw9=0p panw10=0p dtemp=0
TPS1 (net102 S net103 VDD) pfet l=120.0n w=1.9u nf=1 m=1 ngcon=1 rf_rsub=1 plnest=-1 pld200=-1 pwd100=-1 lstis=1 lnws=0 rgatemod=0 rbodymod=0 panw1=0p panw2=0p panw3=0p panw4=0p panw5=0p panw6=0p panw7=0p panw8=0p panw9=0p panw10=0p dtemp=0
TPRN (L1_TP RN net075 VDD) pfet l=120.0n w=1.43u nf=1 m=1 ngcon=1 rf_rsub=1 plnest=-1 pld200=-1 pwd100=-1 lstis=1 lnws=0 rgatemod=0 rbodymod=0 panw1=0p panw2=0p panw3=0p panw4=0p panw5=0p panw6=0p panw7=0p panw8=0p panw9=0p panw10=0p dtemp=0
TPS3 (net068 S VDD VDD) pfet l=120.0n w=1.43u nf=1 m=1 ngcon=1 rf_rsub=1 plnest=-1 pld200=-1 pwd100=-1 lstis=1 lnws=0 rgatemod=0 rbodymod=0 panw1=0p panw2=0p panw3=0p panw4=0p panw5=0p panw6=0p panw7=0p panw8=0p panw9=0p panw10=0p dtemp=0
TPHLD (net068 net0133 net095 VDD) pfet l=120.0n w=1.43u nf=1 m=1 ngcon=1 rf_rsub=1 plnest=-1 pld200=-1 pwd100=-1 lstis=1 lnws=0 rgatemod=0 rbodymod=0 panw1=0p panw2=0p panw3=0p panw4=0p panw5=0p panw6=0p panw7=0p panw8=0p panw9=0p panw10=0p dtemp=0
simulator lang=spice
.ENDS
