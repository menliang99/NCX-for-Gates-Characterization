simulator lang=spice
// Design: JOLPE_test/buffer_a
.SUBCKT buffer_a a GND VDD z
simulator lang=spectre
//include "/mscad/foundry/GF_65/chrt65lpe_V1500RF_DK011_IC61_Rev7/cmos10lpe/../models/YI-SM00030/Spectre/design.scs"
//include "/mscad/foundry/GF_65/chrt65lpe_V1500RF_DK011_IC61_Rev7/cmos10lpe/../models/YI-SM00050/Spectre/design_rfaddm.scs"

// JOLPE_test/buffer_a/schematic
T1 (iz a GND GND) nfet l=120.0n w=160.0n nf=1 m=1 ngcon=1 rf_rsub=1 plnest=-1 pld200=-1 pwd100=-1 lstis=1 lnws=0 rgatemod=0 rbodymod=0 panw1=0p panw2=0p panw3=0p panw4=0p panw5=0p panw6=0p panw7=0p panw8=0p panw9=0p panw10=0p dtemp=0
T3 (z iz GND GND) nfet l=120.0n w=160.0n nf=1 m=1 ngcon=1 rf_rsub=1 plnest=-1 pld200=-1 pwd100=-1 lstis=1 lnws=0 rgatemod=0 rbodymod=0 panw1=0p panw2=0p panw3=0p panw4=0p panw5=0p panw6=0p panw7=0p panw8=0p panw9=0p panw10=0p dtemp=0
T0 (iz a VDD VDD) pfet l=120.0n w=160.0n nf=1 m=1 ngcon=1 rf_rsub=1 plnest=-1 pld200=-1 pwd100=-1 lstis=1 lnws=0 rgatemod=0 rbodymod=0 panw1=0p panw2=0p panw3=0p panw4=0p panw5=0p panw6=0p panw7=0p panw8=0p panw9=0p panw10=0p dtemp=0
T2 (z iz VDD VDD) pfet l=120.0n w=360.0n nf=1 m=1 ngcon=1 rf_rsub=1 plnest=-1 pld200=-1 pwd100=-1 lstis=1 lnws=0 rgatemod=0 rbodymod=0 panw1=0p panw2=0p panw3=0p panw4=0p panw5=0p panw6=0p panw7=0p panw8=0p panw9=0p panw10=0p dtemp=0
simulator lang=spice
.ENDS
